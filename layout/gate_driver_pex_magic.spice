* NGSPICE file created from gate_driver.ext - technology: ihp-sg13g2

.subckt nmos a_68_n36# sub a_94_0# a_0_0#
X0 a_94_0# a_68_n36# a_0_0# sub sg13_lv_nmos ad=1.7p pd=10.68u as=1.7p ps=10.68u w=5u l=0.13u
C0 a_94_0# a_68_n36# 0.02981f
C1 a_68_n36# a_0_0# 0.02981f
C2 a_94_0# a_0_0# 0.27205f
C3 a_94_0# sub 0.25671f
C4 a_0_0# sub 0.25671f
.ends

.subckt pmos a_68_n36# w_n62_n62# sub a_94_0# a_0_0#
X0 a_94_0# a_68_n36# a_0_0# w_n62_n62# sg13_lv_pmos ad=3.4p pd=20.68u as=3.4p ps=20.68u w=10u l=0.13u
C0 a_0_0# w_n62_n62# 0.08875f
C1 a_94_0# a_68_n36# 0.05961f
C2 w_n62_n62# a_68_n36# 0.13674f
C3 a_94_0# w_n62_n62# 0.08875f
C4 a_0_0# a_68_n36# 0.05961f
C5 a_0_0# a_94_0# 0.5441f
C6 a_94_0# sub 0.35358f
C7 a_0_0# sub 0.35358f
.ends

.subckt gate_driver IN OUT VSS VDD
Xnmos_0 IN VSS OUT VSS nmos
Xpmos_0 IN VDD VSS OUT VDD pmos
C0 OUT IN 0.02751f
C1 IN VDD 0.03188f
C2 OUT VDD 0.01586f
C3 VDD VSS 0.19382f
C4 OUT VSS 0.13553f
C5 IN VSS 0.29803f
.ends
